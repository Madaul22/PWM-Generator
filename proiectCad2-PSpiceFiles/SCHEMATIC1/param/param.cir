** Profile: "SCHEMATIC1-param"  [ C:\Users\peleg\Desktop\Proiect Cad Final\proiectcad2\proiectcad2-pspicefiles\schematic1\param.sim ]

** Creating circuit file "param.cir"
** WARNING: THIS AUTOMATICALLY GENERATED FILE MAY BE OVERWRITTEN BY SUBSEQUENT SIMULATIONS

*Libraries:
* Profile Libraries :
* Local Libraries :
* From [PSPICE NETLIST] section of E:\orcadx\cdssetup\OrCAD_PSpice\24.1.0\PSpice.ini file:
.lib "nom.lib"

*Analysis directives:
.TRAN  0 600u 0 0.5u
.STEP LIN PARAM fumax 0.35 0.75 0.05
.OPTIONS ADVCONV
.PROBE64 V(alias(*)) I(alias(*)) W(alias(*)) D(alias(*)) NOISE(alias(*))
.INC "..\SCHEMATIC1.net"

.END
